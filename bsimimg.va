// ********************************************************
// **** BSIM-IMG 102.7.0beta  ****/
// *  BSIM Independent Multi-Gate Model (Verilog-A)
// *  four terminal device (d, fg, s, bg)
// ********************************************************
//
// ********************************************************
// * Copyright 2015 Regents of the University of California.
// * All rights reserved.
// *
// * Project Director: Prof. Chenming Hu.
// * Authors: Chung-Hsun Lin, Mohan Dunga, Darsen Lu,
// *          Sriramkumar V., Shijing Yao,
// *          Srivatsava Jandhyala, Navid Paydavosi,
// *          Yogesh Singh Chauhan, Sourabh Khandelwal,
// *          Pragya Kushwaha, Juan Pablo Duarte,
// *          Ali Niknejad, Chenming Hu
// ********************************************************

// ********************************************************
// ********************************************************
// *   NONDISCLOSURE STATEMENT
// Software is distributed as is, completely without warranty or service
// support. The University of California and its employees are not liable
// for the condition or performance of the software.
// The University of California owns the copyright and grants users a perpetual,
// irrevocable, worldwide, non-exclusive, royalty-free license with
// respect to the software as set forth below.
// The University of California hereby disclaims all implied warranties.
// The University of California grants the users the right to modify, copy,
// and redistribute the software and documentation, both within the user's
// organization and externally, subject to the following restrictions
// 1. The users agree not to charge for the University of California code
// itself but may charge for additions, extensions, or support.
// 2. In any product based on the software, the users agree to acknowledge
// the University of California that developed the software. This
// acknowledgment shall appear in the product documentation.
// 3. The users agree to obey all U.S. Government restrictions governing
// redistribution or export of the software.
// 4. The users agree to reproduce any copyright notice which appears on
// the software on any copy or modification of such made available
// to others
// Agreed to on __April, 2015_________________
// By: ___University of California, Berkeley____
//     ___Chenming Hu_____________________
//     ___Professor in Graduate School _______
// ********************************************************
// ********************************************************

`include "constants.vams"
`include "disciplines.vams"

/**************************************************************/
/* SHMOD is a model parameter                                 */
/*   SHMOD = 1 : Self-heating turned on                       */
/*   SHMOD = 0 : Self-heating turned off                      */
/*                                                            */
/* RDSMOD is a model parameter                                */
/*   RDSMOD = 1 : External source/drain resistance model      */
/*   RDSMOD = 0 : Internal source/drain resistance model      */
/*                                                            */
/* RGATEMOD is a model parameter                              */
/*   RGATEMOD = 1 : Gate Resistance / ge node turned on       */
/*   RGATEMOD = 0 : Gate Resistance / ge node turned off      */
/**************************************************************/
//
// In Verilog-A the number of internal nodes cannot be controlled by
//   a model parameter.  Therefore we use `define statements
//   to control it.  Comment the following lines whenever
//   possible for best computational efficiency.
`define __SHMOD__
`define __RGATEMOD__
`define __RDSMOD__

`include "common_defs.include"
`include "bsimimg_sp_new.include"

(*instance_parameter_list={L,W,NF,AS,AD,PS,PD,NRS,NRD,XL,DTEMP,DELVTRAND,U0MULT}*)

module bsimimg(d, fg, s, bg);
    inout d, fg, s, bg;
    electrical d, fg, s, bg;

`ifdef __RDSMOD__
    electrical di, si;
`endif

`ifdef __RGATEMOD__
   electrical gi;
`endif

`ifdef __SHMOD__
    thermal t;
    branch (t) rth_branch;
    branch (t) ith_branch;
`endif

`include "bsimimg_body.include"

endmodule
